** sch_path: /home/ttuser/Documents/tt_bl_inverter/xschem/bl_inverter.sch
.subckt bl_inverter VDD bl_v_in bl_v_out VSS
*.PININFO VDD:B VSS:B bl_v_in:I bl_v_out:O
XM2 bl_v_1 bl_v_in VSS VSS sky130_fd_pr__nfet_01v8 L=0.15 W=1 nf=1 m=1
XM4 bl_v_out bl_v_1 VSS VSS sky130_fd_pr__nfet_01v8 L=0.15 W=20 nf=20 m=1
XM5 bl_v_1 bl_v_in VDD VDD sky130_fd_pr__pfet_01v8 L=0.15 W=1 nf=1 m=1
XM1 bl_v_out bl_v_1 VDD VDD sky130_fd_pr__pfet_01v8 L=0.15 W=20 nf=20 m=1
.ends
.end
